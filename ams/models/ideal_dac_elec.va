`include "disciplines.vams"
// Ideal DAC with digital input and electrical output (conceptual template)
module ideal_dac_elec #(parameter integer BITS = 8, parameter real VFS = 1.0) (
  input  [BITS-1:0] code,
  output electrical vout
);
  real vreal;
  analog begin
    vreal = (code * 1.0) / ((1<<BITS) - 1) * (2.0*VFS) - VFS;
    V(vout) <+ transition(vreal, 0, 0); // ideal, zero delay/edge
  end
endmodule
